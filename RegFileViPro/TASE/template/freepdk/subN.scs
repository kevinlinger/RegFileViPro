subckt N_TRANSISTOR D G S B

parameters width=90n length=50n

NX (D G S B) NMOS_VTL w=width l=length

ends N_TRANSISTOR
