subckt N_TRANSISTOR D G S B

parameters width=90n length=90n

NX (D G S B) NFET w=width l=length

ends N_TRANSISTOR
