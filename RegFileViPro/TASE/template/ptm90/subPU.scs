subckt PU_TRANSISTOR S G D B

parameters width=90n length=90n

PX (S G D B) PFET w=width l=length

ends PU_TRANSISTOR
