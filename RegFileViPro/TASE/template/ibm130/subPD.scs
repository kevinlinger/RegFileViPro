subckt PD_TRANSISTOR D G S B

parameters width=160n length=120n

NX (D G S B) nfet w=width l=length

ends PD_TRANSISTOR
