subckt PG_TRANSISTOR D G S B

parameters width=0.6u length=0.15u

NX (D G S B) n_std_mvt w=width l=length

ends PG_TRANSISTOR
