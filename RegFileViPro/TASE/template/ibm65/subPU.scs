subckt PU_TRANSISTOR D G S B

parameters width=80n length=65n pvta=0

PX (D G S B) psvtlppusp w=width l=length m=1 tometer=1 mismatch=1 srcefirst=1 p_vta=pvta

ends PU_TRANSISTOR
