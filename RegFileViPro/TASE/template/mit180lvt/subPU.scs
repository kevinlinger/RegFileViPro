subckt PU_TRANSISTOR S G D B

parameters width=0.6u length=0.15u

PX (S G D B) p_std_lvt w=width l=length

ends PU_TRANSISTOR
