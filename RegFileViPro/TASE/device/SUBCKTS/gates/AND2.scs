subckt NAND2 VDD VSS IN1 IN2 OUT

parameters pw pl nw nl

P1 (VDD IN1 COM VDD) P_TRANSISTOR width=pw length=pl

P2 (COM IN2 MID VDD) P_TRANSISTOR width=pw length=pl

N1 (MID IN1 VSS VSS) N_TRANSISTOR width=nw length=nl

N2 (MID IN2 VSS VSS) N_TRANSISTOR width=nw length=nl

P1 (VDD MID OUT VDD) P_TRANSISTOR width=pw length=pl

N1 (OUT MID VSS VSS) N_TRANSISTOR width=nw length=nl

ends NAND2
