//============================================
// Define VDD and VSS
//============================================

VVDD (VDD 0) vsource dc=pvdd
VVSS (VSS 0) vsource dc=0

//============================================
// Source that will swing VGS from 0V to VDD
//============================================

VVGS (VGS VSS) vsource

//============================================
// Drain bias
//============================================

//VVDS1 (VDS1 VSS) vsource dc=pvdd
VVDS2 (VDS2 VSS) vsource dc=0.3

//============================================
// Test transistor WE USE THE PD DEVICE FOR THIS
//============================================

//N1 (VDS1 VGS VSS VSS) N_TRANSISTOR width=wdef length=ldef
N2 (VDS2 VGS VSS VSS) N_TRANSISTOR width=wdef length=ldef
