simulator lang=spectre

include "../../../SUBCKTS/bitcell.scs"

// Voltage sources
_VDD (VDD 0) vsource dc=pvdd
_VBP (VBP 0) vsource dc=pvdd
_VSS (VSS 0) vsource dc=0
_VBN (VBN 0) vsource dc=0

_VWL (WL 0) vsource dc=0
_VBL (BL 0) vsource dc=pvdd
_VBLB (BLB 0) vsource dc=pvdd

// Devices
ICell (BL BLB WL VDD VBP VSS VBN) BITCELL

// DC convergence
nodeset ICell.Q=0 ICell.QB=pvdd
