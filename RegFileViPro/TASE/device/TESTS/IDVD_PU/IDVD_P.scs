//============================================
// Define VDD and VSS
//============================================

VVDD (VDD 0) vsource dc=pvdd
VVSS (VSS 0) vsource dc=0

//============================================
// Gate voltages
//============================================

VVGS1 (VGS1 VDD) vsource dc=pvdd*-0.2
VVGS2 (VGS2 VDD) vsource dc=pvdd*-0.4
VVGS3 (VGS3 VDD) vsource dc=pvdd*-0.6
VVGS4 (VGS4 VDD) vsource dc=pvdd*-0.8
VVGS5 (VGS5 VDD) vsource dc=pvdd*-1.0

//============================================
// Source that will swing VSD from 0V to -VDD
// 	to generate IDVD curves
//============================================

VVDS (VDS VDD) vsource

//============================================
// Five transistors to generate the five IDVD
//	curves
//============================================

P1 (VDS VGS1 VDD VDD) P_TRANSISTOR width=wdef length=ldef
P2 (VDS VGS2 VDD VDD) P_TRANSISTOR width=wdef length=ldef
P3 (VDS VGS3 VDD VDD) P_TRANSISTOR width=wdef length=ldef
P4 (VDS VGS4 VDD VDD) P_TRANSISTOR width=wdef length=ldef
P5 (VDS VGS5 VDD VDD) PU_TRANSISTOR width=wdef length=ldef
