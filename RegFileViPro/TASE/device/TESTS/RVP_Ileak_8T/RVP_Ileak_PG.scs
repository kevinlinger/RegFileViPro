//============================================
// To extract DIBL coefficient
// Id ~ VDS (VGS=0)
//============================================

//============================================
// Define VDD and VSS
//============================================

VVDD (VDD 0) vsource dc=pvdd
VVSS (VSS 0) vsource dc=0

//============================================
// Gate bias
//============================================

VVGS1 (VGS1 VSS) vsource dc=0

//============================================
// Drain bias
//============================================

VVDS (VDS VSS) vsource dc=pvdd

//============================================
// Test transistor
//============================================

N1 (VDS VSS mid VSS) PG_TRANSISTOR width=wrd1 length=lrd1
N2 (VSS VDD mid VSS) PG_TRANSISTOR width=wrdpg length=wrdpg
