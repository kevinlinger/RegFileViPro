// write time simulation
//SRAM  use PTM models
//
// RWM   --2/23/2009

/////////////////////////////////////////////////////
// Options
/////////////////////////////////////////////////////
//// Options set here will be overwritten by the values set in OCEAN script;
//// So options will be set in OCEAN script
////WRITE time simulation

// voltages
VVDD ( VDD 0 ) vsource dc=pvdd
VVSS ( VSS 0 ) vsource dc=0
VVBL ( BL 0 ) vsource dc=0
VBLB ( BLB 0 ) vsource dc=pvdd
//VVWL ( VWL 0 ) vsource dc=0
VVBN ( VBN 0 ) vsource dc=0

VVWL (VWL 0) vsource type=pulse val0=0 val1=wlv period=50n rise=5p fall=5p width=10n

/////////////////////////////////////////////////////
// SubCircuits:  cell
/////////////////////////////////////////////////////
//  drain gate source substrate
////////////////////////////////

XPpur ( A B VDD VDD ) P_TRANSISTOR width=wpu length=lpu
XNpdr ( A B VSS VBN ) N_TRANSISTOR width=wpd length=lpd
XNpgr ( BL WL A VBN)  N_TRANSISTOR width=wpg length=lpg
XPpul ( B A VDD VDD ) P_TRANSISTOR width=wpu length=lpu
XNpdl ( B A VSS VBN ) N_TRANSISTOR width=wpd length=lpd
XNpgl ( BLB WL B VBN) N_TRANSISTOR width=wpg length=lpg

nodeset A=pvdd B=0

//// Load
//c1 ( A 0 ) capacitor c=.03f
//c2 ( B 0 ) capacitor c=.03f
c3 (A B) capacitor c=nncap
