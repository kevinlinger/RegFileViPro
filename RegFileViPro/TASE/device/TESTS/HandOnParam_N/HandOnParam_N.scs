//============================================
// Define VDD and VSS
//============================================

VVDD (VDD 0) vsource dc=pvdd
VVSS (VSS 0) vsource dc=0

//============================================
// Source that will swing VGS from 0V to VDD
//============================================

VVGS (VGS VSS) vsource

//============================================
// Drain bias
//============================================

 VVDS (VDS VSS) vsource dc=pvdd

//============================================
// Body bias
//============================================

VVB1 (VB1 VSS) vsource dc=0
VVB2 (VB2 VSS) vsource dc=0.1*pvdd

//============================================
// Test transistor
//============================================

N1 (VDS VGS VSS VB1) PG_TRANSISTOR width=wdef length=ldef
N2 (VDS VGS VSS VB2) PG_TRANSISTOR width=wdef length=ldef
