//============================================
// Define VDD and VSS
//============================================
VVDD (VDD 0) vsource dc=pvdd
VVSS (VSS 0) vsource dc=0

//============================================
// Half cell
//============================================
subckt HALFCELL (IN OUT BL WL VDD VBP VSS VBN)
  MP (OUT IN VDD VBP) PU_TRANSISTOR width=wpu length=lpu
  MN (OUT IN VSS VBN) PD_TRANSISTOR width=wpd length=lpd
  MT (BL WL OUT VBN) PG_TRANSISTOR width=wpg length=lpg
ends HALFCELL

ICellAh (QB Q BL WL VDD VBP VSS VSS) HALFCELL
ICellBh (Q QB BLB WL VDD VBP VSS VSS) HALFCELL

VVBL (BL 0) vsource dc=pvdd
VVBLB (BLB 0) vsource dc=pvdd
VVWL (WL 0) vsource dc=0
VVBP (VBP 0) vsource dc=pvbp

nodeset Q=0 QB=pvdd
