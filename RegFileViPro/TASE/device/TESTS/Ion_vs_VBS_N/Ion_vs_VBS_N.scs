//============================================
// Define VDD and VSS
//============================================

VVDD (VDD 0) vsource dc=pvdd
VVSS (VSS 0) vsource dc=0

//============================================
// Gate bias
//============================================

VVGS (VGS VSS) vsource dc=pvdd

//============================================
// Drain bias
//============================================

VVDS (VDS VSS) vsource dc=pvdd

//============================================
// Body bias
//============================================

VVBS (VBS VSS) vsource

//============================================
// Test transistor
//============================================

N1 (VDS VGS VSS VBS) N_TRANSISTOR width=wdef length=ldef
