simulator lang=spectre
//============================================
// Define VDD and VSS
//============================================
_VDD (VDD 0) vsource dc=vdd
_VSS (VSS 0) vsource dc=0

//============================================
//============================================

// FSL45_TEST/dc_nodeset/schematic
_C1 (V1 0) capacitor c=1p
_C0 (VDD V1) capacitor c=1p

//==================
//Initial Conditions
//==================
nodeset V1=0.5
