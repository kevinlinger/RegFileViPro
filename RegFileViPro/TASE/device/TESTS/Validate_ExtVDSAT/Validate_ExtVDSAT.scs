//============================================
// Define VDD and VSS
//============================================

VVDD (VDD 0) vsource dc=pvdd
VVSS (VSS 0) vsource dc=0

//============================================
// Gate voltages
//============================================

VVGS1 (VGS1 VSS) vsource dc=pvdd
VVGS2 (VGS2 VSS) vsource dc=0.75*pvdd
VVGS3 (VGS3 VSS) vsource dc=0.5*pvdd
VVGS4 (VGS4 VSS) vsource dc=0.25*pvdd

//============================================
// Source that will swing VDS from 0V to VDD
// 	to generate IDVD curves
//============================================

VVDS (VDS VSS) vsource

//============================================
// Five transistors  to generate the five IDVD
//	curves
//============================================

N1 (VDS VGS1 VSS VSS) N_TRANSISTOR width=wdef length=ldef
N2 (VDS VGS2 VSS VSS) N_TRANSISTOR width=wdef length=ldef
N3 (VDS VGS3 VSS VSS) N_TRANSISTOR width=wdef length=ldef
N4 (VDS VGS4 VSS VSS) N_TRANSISTOR width=wdef length=ldef
