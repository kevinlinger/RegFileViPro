//Generated for; spectre
//Trying to find the gate cap of the WL transistor

simulator lang=spectre
global 0

parameters gcap=7e-15 pwidth=1e-09 pfall=2e-11 prise=2e-11 pvin=0 \
    minw=1.2e-07 minl=6e-08 pvbp=1.1 pvdd=1.1 ldef=6e-08
include "../../../../template/ibm65/include_mm.scs"
include "../../../../template/ibm65/subN.scs"
include "../../../../template/ibm65/subP.scs"
//============================================
// Define VDD and VSS
//============================================
VVDD (VDD 0) vsource dc=pvdd
VVSS (VSS 0) vsource dc=0
VVBP (VBP 0) vsource dc=pvbp
VVBN (VBN 0) vsource dc=0

subckt INV (OUT IN VDD VBP VSS VBN)
parameters wdef=minw ldef=minl
MP (OUT IN VDD VBP) P_TRANSISTOR width=2*wdef length=ldef
MN (OUT IN VSS VBN) N_TRANSISTOR width=wdef length=ldef
ends INV

I0 (OUT0 IN VDD VBP VSS VBN) INV
I1 (OUT1 OUT0 VDD VBP VSS VBN) INV wdef=4*minw
I2 (OUT2 OUT1 VDD VBP VSS VBN) INV wdef=8*minw
I3 (OUT3 OUT1 VDD VBP VSS VBN) INV wdef=8*minw
I4 (OUT4 OUT2 VDD VBP VSS VBN) INV wdef=32*minw

CL (OUT3 0) capacitor c=gcap

VIN (IN 0) vsource type=pulse val0=0 val1=pvdd rise=prise fall=pfall width=pwidth

myOption options pwr=all
simulatorOptions options reltol=1e-06 vabstol=1e-6 iabstol=1e-12 temp=27 \
    tnom=27 scalem=1.0 scale=1.0 gmin=1e-22 rforce=1 maxnotes=5 maxwarns=5 \
    digits=5 cols=80 pivrel=1e-3 sensfile="OUT/psf/sens.output" \
    checklimitdest=psf
tran tran stop=4e-09 errpreset=conservative start=0 step=2e-12 \
    write="spectre.ic" writefinal="spectre.fc" annotate=status maxiters=5
finalTimeOP info what=oppoint where=rawfile
modelParameter info what=models where=rawfile
element info what=inst where=rawfile
outputParameter info what=output where=rawfile
designParamVals info what=parameters where=rawfile
primitives info what=primitives where=rawfile
subckts info what=subckts  where=rawfile
saveOptions options save=allpub currents=all
