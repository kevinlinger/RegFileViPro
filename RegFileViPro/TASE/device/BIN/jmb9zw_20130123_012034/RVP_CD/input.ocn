;; POWER-DELAY CHARACTERIZATION OF CD
;; Satya Nalam 03-28-2010

;; set simulator
simulator( 'spectre)
(envSetVal "spectre.opts" "multithread" 'string "on")
(envSetVal "spectre.opts" "nthreads" 'string "3")

;; set model lists
modelFile(
    '("../../../../template/ibm65/include_mm.scs")
    '("../../../../template/ibm65/subN.scs")
    '("../../../../template/ibm65/subP.scs")
    '("../../../../template/ibm65/subPU.scs")
    '("../../../../template/ibm65/subPD.scs")
    '("../../../../template/ibm65/subPG.scs")
)

;; open file for writing characterization results
of = outfile("datar.txt","w")

; reduce the loops to a single iteration if only getting metrics for a particular configuration
; sweep rows at only those points that correspond to col-mux of 1,2,4 or 8.
; initialize rows to correspond to col-mux of 8 if sweeping, otherwise to specified number of rows.
char = 0
numWords = 16384/16
if( char == 1 then
	maxRows = 512  ;;upper limit 512 rows
	rows = 16 ;;lower limit of 16 rows
	;rowStep = (maxRows-rows)/5 ;ensure we get atleast 5 points for the row sweep
	rowStep = 2
else
	maxRows = 32
	rows = 32
	rowStep = 2
)

;; sweep rows
while( (rows <= maxRows)

	colMux = 8
	bcType = "<bcType>"
	;; Copy appropriate READ netlist
	if( colMux ==1 then
		if( bcType=="6T" then
			cpnetlist = "cp -f ./READ/netlist_one netlist"
		else
			cpnetlist = "cp -f ./READ/netlist_one_8T netlist"
		)
	else
		if( bcType=="6T" then
			cpnetlist = "cp -f ./READ/netlist_mult netlist"
		else
			cpnetlist = "cp -f ./READ/netlist_mult_8T netlist"
		)
	)
	sh( cpnetlist )
	design(  "./netlist")
	resultsDir("./OUTR")

	VDD = 1.1
	desVar(	  "wpu" 160e-9	)
	desVar(	  "lpu" 120e-9	)
	desVar(	  "wpd" 400e-9	)
	desVar(	  "lpd" 120e-9	)
	desVar(	  "wpg" 270e-9	)
	desVar(	  "lpg" 125e-9	)
	desVar( "WLOffset" 0 )
	desVar( "wrd1" 160e-9 )
	desVar( "lrd1" 120e-9 )
	desVar( "wrdpg" 160e-9   )
	desVar( "lrdpg" 120e-9   )
	desVar(   "numBanks" 4)
	desVar("ldef" 60e-9)
	desVar("wdef" 120e-9)
	desVar("tper" 5e-9)
	desVar("trf" 1e-12)
	desVar("tdly" 1.25e-9)
	desVar("cbl" 5.08303e-17)
	desVar("cwl" 1.09136e-16)
	desVar("cg" 6.59722e-16)
	desVar("ws" 16)
	desVar("wnio" 10*120e-9)
	desVar("pvdd" VDD    )

	temp( 25 )
	option( 'reltol 1e-3 'gmin 1e-22)
	desVar("NR" rows)
	desVar("colMux" colMux-1) ;unused if col-mux is 1

	desVar("twl" 5e-9/2)
	analysis('tran ?start 0 ?stop 1.1*5e-9 ?step 0.01n ?strobeperiod 0.001n ?errpreset 'moderate)
	run()

	; time required for given bitline differential, tper should be sufficiently large
	selectResults('tran)
	if( bcType=="6T" then
		dly_bldis = cross(v("BL") VDD-0.15 1 'falling) - cross(v("WLA") VDD/2 1 'rising)
	else
		dly_bldis = cross(v("RBL") VDD-0.15 1 'falling) - cross(v("WLA") VDD/2 1 'rising)
	)

	; run analysis with wl width just enough for given bitline differential
	desVar("twl" dly_bldis)
	analysis('tran ?start 0 ?stop 1.1*5e-9 ?step 0.01n ?strobeperiod 0.001n ?errpreset 'moderate)
	run()

	;; measure power - all columns discharge doing either dummy read or full read.
	selectResults('tran)
	avg_pwr_r = average(getData("ICOL1.ICDA:pwr"))
	avg_pwrbc_r = average(getData("ICOL1.IBCA:pwr"))
	avg_pwr_pch_buf= average(getData("IPCH:pwr"))

	if( bcType=="6T" then
		dly_pch_r=cross(v("BL") VDD*.95 1 'rising) - cross(v("PCH") VDD/2 1 'falling)
	else
		dly_pch_r=cross(v("RBL") VDD*.95 1 'rising) - cross(v("PCH") VDD/2 1 'falling)
	)

	if( colMux>1 then
		avg_pwr_hs = average(getData("ICOLD.ICDA:pwr"))
		avg_pwrbc_hs = average(getData("ICOLD.IBCA:pwr"))
	else
		avg_pwr_hs = 0
		avg_pwrbc_hs = 0
	)

	energycd_r = 16*(avg_pwr_r+avg_pwr_hs)*1.1*5e-9
	energybc_r = 16*(avg_pwrbc_r+avg_pwrbc_hs)*1.1*5e-9
	energy_inter_r=1.1*5e-9*avg_pwr_pch_buf
	dly_inter_r=cross(v("PCH") VDD*.95 1 'rising) - cross(v("PCH_IN") VDD/2 1 'rising)

	;; write data to file
	fprintf(of,"%d\t%d\t%d\t%e\t%e\t%e\t%e\t%e\t%e\n", 4, rows, colMux, dly_bldis, dly_pch_r, energycd_r, energybc_r, energy_inter_r,dly_inter_r)
	rows = rows*rowStep
	drain(of)
)
close(of)

;;;;;;;;;;;;;;;;;;;;;;;;;;;;;;;;;;;;;;;;;;;;;;;;;;;;;;;;;;;;;;;;;;;;;;;;;;;;;;;;;;;;;;;;;;;;;;;;;;;;;
;;; Write calculations

;; open file for writing characterization results
of = outfile("dataw.txt","w")

;reinitialize rows
if( char == 1 then
	rows = 16
else
	rows = 32
)

;; sweep rows
while( (rows <= maxRows)

	colMux = 8
	;; Copy appropriate WRITE netlist
	if( colMux ==1 then
		cpnetlist = "cp -f ./WRITE/netlist_one netlist"
	else
		cpnetlist = "cp -f ./WRITE/netlist_mult netlist"
	)
	sh( cpnetlist )
	design(  "./netlist")

	resultsDir("./OUTW")

	VDD = 1.1
	desVar(	  "wpu" 160e-9	)
	desVar(	  "lpu" 120e-9	)
	desVar(	  "wpd" 400e-9	)
	desVar(	  "lpd" 120e-9	)
	desVar(	  "wpg" 270e-9	)
	desVar(	  "lpg" 125e-9	)

	;PD width of IO driver chosen arbitrarily as it doesn't affect CD measurements mostly - assuming its contribution to cap is small compared to all other bitline cap components.
	desVar("ldef" 60e-9)
	desVar("wdef" 120e-9)
	desVar("tper" 5e-9)
	desVar("trf" 1e-12)
	desVar( "WLOffset" 0 )
	desVar("twl" 5e-9/6)
	desVar("tdly" 1.25e-9)
	desVar("cbl" 5.08303e-17)
	desVar("NR" rows)
	desVar("colMux" colMux-1)
	desVar("pvdd" VDD    )
	desVar("cwl" 1.09136e-16)
	desVar("cg" 6.59722e-16)
	desVar("ws" 16)
	desVar("numBanks" 4)
	temp( 25 )
	option( 'reltol 1e-3 'gmin 1e-22)

	analysis('tran ?start 0 ?stop 1.1*5e-9 ?step 0.01n ?strobeperiod 0.001n ?errpreset 'moderate)
	run()
	selectResult('tran)

	;; measure delays
	;; calculate bitcell flip energy
	avg_pwrbc_w = average(getData("ICOL1.IBCA:pwr"))
	; Bitcell flip delay
	dly_bcwr = cross(v("ICOL1.IBCA.Q") VDD/2 1 'rising) - cross(v("WLA") VDD/2 1 'rising)

	; run analysis with enough WL pulse to just write, to prevent half-selected cells swinging full rail
	desVar("twl" dly_bcwr)
	analysis('tran ?start 0 ?stop 1.1*5e-9 ?step 0.01n ?strobeperiod 0.001n ?errpreset 'moderate)
	run()
	selectResult('tran)

	;; measure delays
	;; BL discharge and precharge delay
	dly_bl_pch = cross(v("BLB") VDD*.95 1 'rising) - cross(v("PCH") VDD/2 1 'falling)
	dly_writeDriver = cross(v("BLB") VDD*.05 1 'falling) - cross(v("WEN") VDD/2 1 'rising)

	;; measure power
	; accessed col cd and bitcell power
	avg_pwr_writeDriver = average(getData("IWRD:pwr"))+average(getData("IWRDB:pwr"))
	avg_pwr_int_w=average(getData("IWEN:pwr"))+average(getData("IPCH:pwr"))
	avg_pwr_w = average(getData("ICOL1.ICDA:pwr"))

	; half-selected col cd and bitcell power if col-mux present
	if( colMux > 1 then
		avg_pwr_hs = average(getData("ICOLD.ICDA:pwr"))
		avg_pwrbc_hs = average(getData("ICOLD.IBCA:pwr"))
	else
		avg_pwr_hs = 0
		avg_pwrbc_hs = 0
	)

	; calculate total CD energy across all selected columns
	energycd_w = 16*(avg_pwr_w + avg_pwr_hs)*1.1*5e-9
	energybc_w = 16*(avg_pwrbc_w + avg_pwrbc_hs)*1.1*5e-9
	energy_writeDriver= 16*avg_pwr_writeDriver*1.1*5e-9
	energy_inter_w=avg_pwr_int_w*1.1*5e-9
	delay_inter_w=cross(v("WEN") VDD*.05 1 'rising) - cross(v("WEN_IN") VDD/2 1 'rising)

	;; write data to file
	fprintf(of,"%d\t%d\t%d\t%e\t%e\t%e\t%e\t%e\t%e\t%e\t%e\n", 4, rows, colMux, dly_bl_pch, dly_writeDriver, dly_bcwr, energycd_w, energybc_w, energy_writeDriver, energy_inter_w, delay_inter_w)
	rows = rows*rowStep
	drain(of)
)
close(of)
