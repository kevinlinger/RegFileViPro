/*
 Ocean script to test robustness of dynamic OR gate
*/

; ************************** main code ***************************
simulator( 'spectre )

;; COPY THE CORRISPONDING NETLIST FOR THE DESIRED DATA PATTERN
design( "./netlist" )

resultsDir("./OUT")
outputFile = outfile( "data.txt" "w" )

modelFile(
	'("../../../../template/ibm65/include_mm.scs")
	'("../../../../template/ibm65/subN.scs")
	'("../../../../template/ibm65/subP.scs")
)

desVar(   "pvdd" 1)
desVar(   "pvbp" 1)
desVar(   "ldef" 60e-9 )
desVar(   "wdef" 120e-9 )
desVar(   "prise" 10e-12 )
desVar(   "pfall" 10e-12 )
desVar(	  "per" 5e-9 )
desVar(	  "ws"  16   )
desVar(   "rows" 64 )
desVar(   "readPorts" 4 )
desVar(   "writePorts" 1 )
desVar(   "capacity" (1024/16) )
desVar( "gblnum" pow(2 3))
desVar( "lblnum" pow(2 3))

pvdd = 1

desVar(   "lblnsize" 1)
desVar(   "lblpsize" 1)
desVar(   "gblnsize" 1)
desVar(   "gblpsize" 1)

analysis('tran ?start 0 ?stop (5e-9*4) ?step 0.1p ?errpreset 'conservative)
temp(27)
option('reltol 1e-6 'gmin 1e-22)
save('all)
ic("LBLout" 0)
run()
selectResults('tran)

tdel = cross(v("Dout") (pvdd/2.0) 1 'falling) - cross(v("C2") (pvdd/2.0) 1 'rising)
;Oldenergy = integ(i("Vvdd.p") 0.01n (5e-9*4))

energy = integ(i("Vvdd.p") 5e-9 (5e-9 + tdel)) + integ(i("Vvdd.p") (5e-9*1.5) (5e-9*1.5 + tdel)) + integ(i("Vvdd.p") (5e-9*2) ((5e-9*2) + tdel)) + integ(i("Vvdd.p") (5e-9*2.5) ((5e-9*2.5) + tdel)) + integ(i("Vvdd.p") (5e-9*3) ((5e-9*3) + tdel)) + integ(i("Vvdd.p") (5e-9*3.5) ((5e-9*3.5) + tdel)) + integ(i("Vvdd.p") (5e-9*4) ((5e-9*4) + tdel)) + integ(i("Vvdd.p") (5e-9*4.5) ((5e-9*4.5) + tdel))

avgenergy = energy/4.0

;plot( v("C1") v("C2") v("C1Bar") v("C2Bar") v("In1") v("LBLout") v("GBLin") v("GBLout") v("Dout") )

fprintf(outputFile "%e\n", tdel)
fprintf(outputFile "%e\n", (avgenergy*-1*4*16))

close( outputFile )
