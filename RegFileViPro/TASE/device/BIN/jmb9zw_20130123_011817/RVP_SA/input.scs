//Trying to find the gate cap of the WL transistor

simulator lang=spectre
global 0

parameters twl=1e+09 BL_DIFF=0.15 numBanks=4 cwl=1.09136e-16 ws=16 pvdd=1.1 colMux=8 cbl=5.08303e-17 tdly=1.25e-09 trf=1e-12 tper=5e-09 wdef=1.2e-07 ldef=6e-08 cg=6.59722e-16 lpg=1.25e-07 wpg=2.7e-07 lpd=1.2e-07 wpd=4e-07 lpu=1.2e-07 wpu=1.6e-07 cwire=5.238528e-15
include "../../../../template/ibm65/include_mm.scs"
include "../../../../template/ibm65/subN.scs"
include "../../../../template/ibm65/subP.scs"
include "../../../../template/ibm65/subPU.scs"
include "../../../../template/ibm65/subPD.scs"
include "../../../../template/ibm65/subPG.scs"
////Cell name: buf
subckt buf IN OUT VDD VSS
parameters wp2=wdef wp1=wdef wn2=wdef wn1=wdef l=ldef
MP1 (OUTB IN VDD VDD) P_TRANSISTOR width=wp1 length=l
MN1 (OUTB IN VSS VSS) N_TRANSISTOR width=wn1 length=l
MP2 (OUT OUTB VDD VDD) P_TRANSISTOR width=wp2 length=l
MN2 (OUT OUTB VSS VSS) N_TRANSISTOR width=wn2 length=l
ends buf

//Inverter subcircuit
subckt INV OUT IN VDD VSS
parameters i
MP (OUT IN VDD VDD) P_TRANSISTOR width=2*i*wdef length=ldef
MN (OUT IN VSS VSS) N_TRANSISTOR width=i*wdef length=ldef
ends INV

// Cell name: nand2
// View name: schematic
subckt nand2 INbot INtop OUT VDD VSS
parameters wp=2*wdef lp=ldef wn=2*wdef ln=ldef
M2 (OUT INtop VDD VDD) P_TRANSISTOR width=wp length=lp
MP (OUT INbot VDD VDD) P_TRANSISTOR width=wp length=lp
M1 (OUT INtop net048 VSS) N_TRANSISTOR width=wn length=ln
M3 (net048 INbot VSS VSS) N_TRANSISTOR width=wn length=ln
ends nand2

// Cell name: SA
// View name: schematic
subckt SA NRDWR RDWR SAE SAPREC SD VDD VSS
I5 (SD OUT SDB VDD VSS) nand2 wp=wdef lp=ldef wn=wdef ln=ldef
I34 (SDB OUTB SD VDD VSS) nand2 wp=wdef lp=ldef wn=wdef ln=ldef
M19 (COM SAE VSS VSS) N_TRANSISTOR width=wdef length=ldef
M11 (xinb NRDWR COM VSS) N_TRANSISTOR width=wdef length=ldef
M10 (xin RDWR COM VSS) N_TRANSISTOR width=wdef length=ldef
M8 (OUTB OUT xin VSS) N_TRANSISTOR width=3*wdef length=ldef
M7 (OUT OUTB xinb VSS) N_TRANSISTOR width=3*wdef length=ldef
M20 (NRDWR SAPREC VDD VDD) P_TRANSISTOR width=5*wdef length=ldef
M24 (xinb SAE VDD VDD) P_TRANSISTOR width=wdef length=ldef
M23 (xin SAE xinb VDD) P_TRANSISTOR width=wdef length=ldef
M25 (xin SAE VDD VDD) P_TRANSISTOR width=wdef length=ldef
M14 (RDWR SAPREC VDD VDD) P_TRANSISTOR width=5*wdef length=ldef
M5 (OUT OUTB VDD VDD) P_TRANSISTOR width=wdef length=ldef
M4 (OUTB OUT VDD VDD) P_TRANSISTOR width=wdef length=ldef
M3 (OUTB SAE OUT VDD) P_TRANSISTOR width=wdef length=ldef
M2 (OUT SAE VDD VDD) P_TRANSISTOR width=wdef length=ldef
M1 (OUTB SAE VDD VDD) P_TRANSISTOR width=wdef length=ldef
ends SA

// Cell name: col mux
// View name: schematic
subckt col_mux BL BLB CSEL CSELB NRDWR RDWR VDD VSS
parameters wncs=wdef lncs=ldef wpcs=wdef lpcs=ldef
M3 (BLB CSEL NRDWR VSS) N_TRANSISTOR width=wncs length=lncs
M1 (BL CSEL RDWR VSS) N_TRANSISTOR width=wncs length=lncs
M4 (NRDWR CSELB BLB VDD) P_TRANSISTOR width=wpcs length=lpcs
M2 (RDWR CSELB BL VDD) P_TRANSISTOR width=wpcs length=lpcs
ends col_mux

//generic inverter chain optimize later
subckt INVCHAIN IN OUT VDD VSS
I0 (X1 IN VDD VSS) INV i=1
I1 (X2 X1 VDD VSS) INV i=4
I2 (X3 X2 VDD VSS) INV i=16
I3 (OUT X3 VDD VSS) INV i=48
ends INVCHAIN

VBL (BL 0) vsource dc=pvdd-BL_DIFF
VBLB (BLB 0) vsource dc=pvdd

CwireNDRWR (NRDWR 0) capacitor c=cwire
CwireRDWR (RDWR 0) capacitor c=cwire

//BC and CD
ICOL1 (BL BLB CSEL CSELB NRDWR RDWR VDD VSS) col_mux

//SA
ISA (NRDWR RDWR SAE SAPREC SD VDD VSS) SA

// capacitance of SA driving the tristate buffer (hardcoded for now assuming pmos 16x min, nmos 8x min)
cap1 (SD 0) capacitor c=wdef*cg*1e6*24

//Input drivers for DUT
VVDD (VDD 0) vsource dc=pvdd
VVSS (VSS 0) vsource dc=0

VCSEL (CSEL_IN 0) vsource type=pulse val0=0 val1=pvdd rise=trf fall=trf width=1n period=tper delay=1n
VCSELB (CSELB_IN 0) vsource type=pulse val0=pvdd val1=0 rise=trf fall=trf width=1n period=tper delay=1n

ICSEL (CSEL_IN CSEL VDD VSS) INVCHAIN
ICSELB (CSELB_IN CSELB VDD VSS) INVCHAIN
ISAE (SAE_IN SAE VDD VSS) INVCHAIN
ISAPREC (SAPREC_IN SAPREC VDD VSS) INVCHAIN

VSAE (SAE_IN 0) vsource type=pulse val0=0 val1=pvdd rise=trf fall=trf width=tper/5 period=tper delay=2n
VSAPREC (SAPREC_IN 0) vsource type=pulse val0=0 val1=pvdd rise=trf fall=trf width=tper/2.5 period=tper delay=1n

// CAPS assume that banks placed side by side and signals generated from middle of structure
// wire cap + gate cap for each component
capSAE (SAE 0) capacitor c=numBanks/2*ws*cwl*colMux+wdef*cg*1e6*(ws-1)*7
capSAPREC (SAPREC 0) capacitor c=numBanks/2*ws*cwl*colMux+wdef*cg*1e6*(ws-1)*10
capCSEL (CSEL 0) capacitor c=numBanks/2*ws*cwl*colMux+wdef*cg*1e6*(ws-1)*2
capCSELB (CSELB 0) capacitor c=numBanks/2*ws*cwl*colMux+wdef*cg*1e6*(ws-1)*2

ic ISA.OUT=pvdd ISA.OUTB=pvdd ISA.SD=pvdd ISA.SDB=0
myOption options pwr=all pivotdc=yes
simulatorOptions options reltol=0.001 temp=25 gmin=1e-22
tran tran stop=5.5e-09 errpreset=conservative start=0 step=1e-11 strobeperiod=1e-12
